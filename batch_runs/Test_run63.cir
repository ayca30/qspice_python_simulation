* Test.qsch
V2 N01 0 SIN 0 60 100
L1 N01 N02 L = {L} ISAT=2 LSAT=10µ
R1 0 N02 1
.tran 30m
.param L  = 0.00393492726309585
.end
