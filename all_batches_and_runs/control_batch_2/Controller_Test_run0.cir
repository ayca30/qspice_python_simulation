* Controller_Test.qsch
V2 N01 0 SIN 0 {VAMP} 100
L1 N01 N02 10m ISAT =5 SAT=10µ IC=8082539.188868
R1 0 N02 1
.tran 30m UIC
.param VAMP  = -21007484.0710315
.end
