* Controller_Test.qsch
L1 N01 N02 L=10m ISAT =5 LSAT=10µ
R1 0 N02 1
V1 N01 0 SIN 0 {VAMP} 100
.tran 0 0.01
.param VAMP  = 4
.param VAMP  = 4
.end
